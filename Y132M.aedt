# Ansys Electronics Desktop project, version 2021.1
materials:
  steel_1008: permeability{HUnit=A_per_meter BUnit=tesla curve (0, 0) (159.2, 0.2402) (318.3, 0.8654) (477.5, 1.1106) (636.6, 1.2458) (795.8, 1.331) (1591.5, 1.5) (3183.1, 1.6) (4774.6, 1.683) (6366.2, 1.741) (7957.7, 1.78) (15915.5, 1.905) (31831, 2.025) (47746.5, 2.085) (63662, 2.13) (79577.5, 2.165) (159155, 2.28) (318310, 2.485) (397887, 2.5851)} conductivity=2000000 mass_density=7872
  M19_24G: permeability{HUnit=A_per_meter BUnit=tesla curve (0, 0) (22.28, 0.05) (25.46, 0.1) (31.83, 0.15) (47.74, 0.36) (63.66, 0.54) (79.57, 0.65) (159.15, 0.99) (318.3, 1.2) (477.46, 1.28) (636.61, 1.33) (795.77, 1.36) (1591.5, 1.44) (3183, 1.52) (4774.6, 1.58) (6366.1, 1.63) (7957.7, 1.67) (15915, 1.8) (31830, 1.9) (111407, 2) (190984, 2.1) (350138, 2.3) (509292, 2.5)} conductivity=1960000 core_loss_type="Electrical Steel" core_loss_kh=178.47 core_loss_kc=1.41 core_loss_ke=1.79 mass_density=7650
  copper: permeability=0.999991 conductivity=58000000 mass_density=8933
  vacuum: permittivity=1
  M19_24G_2DSF1.230: permeability{HUnit=A_per_meter BUnit=tesla curve (0, 0) (22.28, 0.0614766) (25.46, 0.122959) (31.83, 0.18444) (47.74, 0.442664) (63.66, 0.663998) (79.57, 0.799256) (159.15, 1.21732) (318.3, 1.4755) (477.46, 1.57383) (636.61, 1.63526) (795.77, 1.67211) (1591.5, 1.77025) (3183, 1.86816) (4774.6, 1.94148) (6366.1, 2.00251) (7957.7, 2.05124) (15915, 2.20879) (31830, 2.32717) (111407, 2.42717) (190984, 2.52717) (350138, 2.72717) (509292, 2.92717) (2100830, 4.92717)} conductivity=1960000 core_loss_type="Electrical Steel" core_loss_kh=145.138 core_loss_kc=1.14666 core_loss_ke=1.61421 mass_density=9406.9
  M19_24G_2DSF0.950: permeability{HUnit=A_per_meter BUnit=tesla curve (0, 0) (22.28, 0.0475014) (25.46, 0.0950016) (31.83, 0.142502) (47.74, 0.342003) (63.66, 0.513004) (79.57, 0.617505) (159.15, 0.94051) (318.3, 1.14002) (477.46, 1.21603) (636.61, 1.26354) (795.77, 1.29205) (1591.5, 1.3681) (3183, 1.4442) (4774.6, 1.5013) (6366.1, 1.5489) (7957.7, 1.587) (15915, 1.711) (31830, 1.807) (111407, 1.907) (190984, 2.007) (350138, 2.207) (509292, 2.407) (2100830, 4.407)} conductivity=1960000 core_loss_type="Electrical Steel" core_loss_kh=187.863 core_loss_kc=1.48421 core_loss_ke=1.8365 mass_density=7267.5
  copper_75C: conductivity=58000000

design Maxwell2DDesign1 (Maxwell 2D, Transient, XY geometry, model units mm)
options: ModelDepth=135.2mm SkewModelType=0 SkewAngle=12.8571deg NumberOfSlices=5 PlotFieldOnSlice=0
variables:
  fractions = 1
geometry:
  Band [vacuum] = user_primitive(RMxprt/Band, DiaGap=131.5mm, DiaYoke=48mm, Length=0mm, SegAngle=0deg, Fractions=1, HalfAxial=0, InfoCore=0)
  Shaft [M19_24G_2DSF0.950] = user_primitive(RMxprt/Band, DiaGap=131.5mm, DiaYoke=48mm, Length=0mm, SegAngle=0deg, Fractions=1, HalfAxial=0, InfoCore=100)
  OuterRegion [vacuum] = user_primitive(RMxprt/Band, DiaGap=131.5mm, DiaYoke=210mm, Length=0mm, SegAngle=0deg, Fractions=fractions, HalfAxial=0, InfoCore=100)
  Tool = user_primitive(RMxprt/Band, DiaGap=131.5mm, DiaYoke=210mm, Length=0mm, SegAngle=0deg, Fractions=fractions, HalfAxial=0, InfoCore=1)
  Stator [M19_24G_2DSF1.230] = user_primitive(RMxprt/SlotCore, DiaGap=132mm, DiaYoke=210mm, Length=0mm, Skew=0deg, Slots=36, SlotType=2, Hs0=0.5mm, Hs01=0mm, Hs1=1mm, Hs2=19.662134mm, Bs0=3mm, Bs1=7.1062086mm, Bs2=10.546636mm, Rs=0mm, FilletType=0, HalfSlot=0, SegAngle=15deg, LenRegion=0mm, InfoCore=0)
  Coil_0 [copper] = user_primitive(RMxprt/LapCoil, DiaGap=132mm, DiaYoke=210mm, Length=0mm, Skew=0deg, Slots=36, SlotType=2, Hs0=0.5mm, Hs1=1mm, Hs2=19.662134mm, Bs0=3mm, Bs1=7.1062086mm, Bs2=10.546636mm, Rs=0mm, FilletType=0, Layers=2, CoilPitch=8, EndExt=0mm, SpanExt=0mm, BendAngle=0deg, SegAngle=10deg, LenRegion=0mm, InfoCoil=2)
  Coil_1..Coil_35 [copper] = Coil_0.duplicate_around_axis(axis=Z, angle=10deg, total=36)
  CoilRe_0 [copper] = user_primitive(RMxprt/LapCoil, DiaGap=132mm, DiaYoke=210mm, Length=0mm, Skew=0deg, Slots=36, SlotType=2, Hs0=0.5mm, Hs1=1mm, Hs2=19.662134mm, Bs0=3mm, Bs1=7.1062086mm, Bs2=10.546636mm, Rs=0mm, FilletType=0, Layers=2, CoilPitch=8, EndExt=0mm, SpanExt=0mm, BendAngle=0deg, SegAngle=10deg, LenRegion=0mm, InfoCoil=3)
  CoilRe_0.rotate(axis=Z, angle=-80deg)
  CoilRe_1..CoilRe_35 [copper] = CoilRe_0.duplicate_around_axis(axis=Z, angle=10deg, total=36)
  Rotor [M19_24G_2DSF0.950] = user_primitive(RMxprt/SlotCore, DiaGap=131mm, DiaYoke=48mm, Length=0mm, Skew=0deg, Slots=28, SlotType=2, Hs0=0.8mm, Hs01=0mm, Hs1=1mm, Hs2=15mm, Bs0=1mm, Bs1=4mm, Bs2=6mm, Rs=0mm, FilletType=0, HalfSlot=0, SegAngle=15deg, LenRegion=0mm, InfoCore=0)
  Bar [copper_75C] = user_primitive(RMxprt/SquirrelCage, DiaGap=131mm, DiaYoke=48mm, Length=0mm, Skew=0deg, Slots=28, SlotType=2, Hs0=0.8mm, Hs01=0mm, Hs1=1mm, Hs2=15mm, Bs0=1mm, Bs1=4mm, Bs2=6mm, Rs=0mm, FilletType=0, HalfSlot=0, BarEndExt=15mm, RingLength=15mm, RingHeight=20mm, RingDiaGap=0mm, CastRotor=1, SegAngle=15deg, LenRegion=0mm, InfoCoil=0)
  Tool_1 = Tool.copy()
  Bar.subtract(Tool_1)
  Bar_Separate1..Bar_Separate27 [copper_75C] = Bar.separate_bodies()
  InnerRegion [vacuum] = user_primitive(RMxprt/SlotCore, DiaGap=131mm, DiaYoke=48mm, Length=0mm, Skew=0deg, Slots=28, SlotType=2, Hs0=0.8mm, Hs01=0mm, Hs1=1mm, Hs2=15mm, Bs0=1mm, Bs1=4mm, Bs2=6mm, Rs=0mm, FilletType=0, HalfSlot=0, SegAngle=15deg, LenRegion=0mm, InfoCore=100)
  Tool_2 = Tool.copy()
  Band.subtract(Tool_2)
  Tool_3 = Tool.copy()
  InnerRegion.subtract(Tool_3)
  Tool_4 = Tool.copy()
  Shaft.subtract(Tool_4)
  Tool_5 = Tool.copy()
  Stator.subtract(Tool_5)
  Tool_6 = Tool.copy()
  Coil_0.subtract(Tool_6)
  Tool_7 = Tool.copy()
  Coil_1.subtract(Tool_7)
  Tool_8 = Tool.copy()
  Coil_2.subtract(Tool_8)
  Tool_9 = Tool.copy()
  Coil_3.subtract(Tool_9)
  Tool_10 = Tool.copy()
  Coil_4.subtract(Tool_10)
  Tool_11 = Tool.copy()
  Coil_5.subtract(Tool_11)
  Tool_12 = Tool.copy()
  Coil_6.subtract(Tool_12)
  Tool_13 = Tool.copy()
  Coil_7.subtract(Tool_13)
  Tool_14 = Tool.copy()
  Coil_8.subtract(Tool_14)
  Tool_15 = Tool.copy()
  Coil_9.subtract(Tool_15)
  Tool_16 = Tool.copy()
  Coil_10.subtract(Tool_16)
  Tool_17 = Tool.copy()
  Coil_11.subtract(Tool_17)
  Tool_18 = Tool.copy()
  Coil_12.subtract(Tool_18)
  Tool_19 = Tool.copy()
  Coil_13.subtract(Tool_19)
  Tool_20 = Tool.copy()
  Coil_14.subtract(Tool_20)
  Tool_21 = Tool.copy()
  Coil_15.subtract(Tool_21)
  Tool_22 = Tool.copy()
  Coil_16.subtract(Tool_22)
  Tool_23 = Tool.copy()
  Coil_17.subtract(Tool_23)
  Tool_24 = Tool.copy()
  Coil_18.subtract(Tool_24)
  Tool_25 = Tool.copy()
  Coil_19.subtract(Tool_25)
  Tool_26 = Tool.copy()
  Coil_20.subtract(Tool_26)
  Tool_27 = Tool.copy()
  Coil_21.subtract(Tool_27)
  Tool_28 = Tool.copy()
  Coil_22.subtract(Tool_28)
  Tool_29 = Tool.copy()
  Coil_23.subtract(Tool_29)
  Tool_30 = Tool.copy()
  Coil_24.subtract(Tool_30)
  Tool_31 = Tool.copy()
  Coil_25.subtract(Tool_31)
  Tool_32 = Tool.copy()
  Coil_26.subtract(Tool_32)
  Tool_33 = Tool.copy()
  Coil_27.subtract(Tool_33)
  Tool_34 = Tool.copy()
  Coil_28.subtract(Tool_34)
  Tool_35 = Tool.copy()
  Coil_29.subtract(Tool_35)
  Tool_36 = Tool.copy()
  Coil_30.subtract(Tool_36)
  Tool_37 = Tool.copy()
  Coil_31.subtract(Tool_37)
  Tool_38 = Tool.copy()
  Coil_32.subtract(Tool_38)
  Tool_39 = Tool.copy()
  Coil_33.subtract(Tool_39)
  Tool_40 = Tool.copy()
  Coil_34.subtract(Tool_40)
  Tool_41 = Tool.copy()
  Coil_35.subtract(Tool_41)
  Tool_42 = Tool.copy()
  CoilRe_0.subtract(Tool_42)
  Tool_43 = Tool.copy()
  CoilRe_1.subtract(Tool_43)
  Tool_44 = Tool.copy()
  CoilRe_2.subtract(Tool_44)
  Tool_45 = Tool.copy()
  CoilRe_3.subtract(Tool_45)
  Tool_46 = Tool.copy()
  CoilRe_4.subtract(Tool_46)
  Tool_47 = Tool.copy()
  CoilRe_5.subtract(Tool_47)
  Tool_48 = Tool.copy()
  CoilRe_6.subtract(Tool_48)
  Tool_49 = Tool.copy()
  CoilRe_7.subtract(Tool_49)
  Tool_50 = Tool.copy()
  CoilRe_8.subtract(Tool_50)
  Tool_51 = Tool.copy()
  CoilRe_9.subtract(Tool_51)
  Tool_52 = Tool.copy()
  CoilRe_10.subtract(Tool_52)
  Tool_53 = Tool.copy()
  CoilRe_11.subtract(Tool_53)
  Tool_54 = Tool.copy()
  CoilRe_12.subtract(Tool_54)
  Tool_55 = Tool.copy()
  CoilRe_13.subtract(Tool_55)
  Tool_56 = Tool.copy()
  CoilRe_14.subtract(Tool_56)
  Tool_57 = Tool.copy()
  CoilRe_15.subtract(Tool_57)
  Tool_58 = Tool.copy()
  CoilRe_16.subtract(Tool_58)
  Tool_59 = Tool.copy()
  CoilRe_17.subtract(Tool_59)
  Tool_60 = Tool.copy()
  CoilRe_18.subtract(Tool_60)
  Tool_61 = Tool.copy()
  CoilRe_19.subtract(Tool_61)
  Tool_62 = Tool.copy()
  CoilRe_20.subtract(Tool_62)
  Tool_63 = Tool.copy()
  CoilRe_21.subtract(Tool_63)
  Tool_64 = Tool.copy()
  CoilRe_22.subtract(Tool_64)
  Tool_65 = Tool.copy()
  CoilRe_23.subtract(Tool_65)
  Tool_66 = Tool.copy()
  CoilRe_24.subtract(Tool_66)
  Tool_67 = Tool.copy()
  CoilRe_25.subtract(Tool_67)
  Tool_68 = Tool.copy()
  CoilRe_26.subtract(Tool_68)
  Tool_69 = Tool.copy()
  CoilRe_27.subtract(Tool_69)
  Tool_70 = Tool.copy()
  CoilRe_28.subtract(Tool_70)
  Tool_71 = Tool.copy()
  CoilRe_29.subtract(Tool_71)
  Tool_72 = Tool.copy()
  CoilRe_30.subtract(Tool_72)
  Tool_73 = Tool.copy()
  CoilRe_31.subtract(Tool_73)
  Tool_74 = Tool.copy()
  CoilRe_32.subtract(Tool_74)
  Tool_75 = Tool.copy()
  CoilRe_33.subtract(Tool_75)
  Tool_76 = Tool.copy()
  CoilRe_34.subtract(Tool_76)
  Tool_77 = Tool.copy()
  CoilRe_35.subtract(Tool_77)
  Rotor.subtract(Tool)
motion:
  MotionSetup1: Band Move_Type=Rotate Coordinate_System=Global Axis=Z Is_Positive=true InitPos=0deg Angular_Velocity=1455rpm Moment_of_Inertia=0.0304899 Damping=0.0124891 Load_Torque=-28NewtonMeter Objects=Band
  Moving1: Moving Objects=[Shaft, Rotor, Bar, Bar_Separate1..Bar_Separate27, InnerRegion]
boundaries and excitations:
  VectorPotential1: Vector Potential Edges=OuterRegion.edge(at (0, 105, 0)) Value=0
  PhA_0: Coil Objects=Coil_0 Conductor_number=18 Winding=PhaseA PolarityType=Positive
  PhARe_0: Coil Objects=CoilRe_8 Conductor_number=18 Winding=PhaseA PolarityType=Negative
  PhA_1: Coil Objects=Coil_1 Conductor_number=18 Winding=PhaseA PolarityType=Positive
  PhARe_1: Coil Objects=CoilRe_9 Conductor_number=18 Winding=PhaseA PolarityType=Negative
  PhA_2: Coil Objects=Coil_2 Conductor_number=18 Winding=PhaseA PolarityType=Positive
  PhARe_2: Coil Objects=CoilRe_10 Conductor_number=18 Winding=PhaseA PolarityType=Negative
  PhCRe_3: Coil Objects=Coil_3 Conductor_number=18 Winding=PhaseC PolarityType=Negative
  PhC_3: Coil Objects=CoilRe_11 Conductor_number=18 Winding=PhaseC PolarityType=Positive
  PhCRe_4: Coil Objects=Coil_4 Conductor_number=18 Winding=PhaseC PolarityType=Negative
  PhC_4: Coil Objects=CoilRe_12 Conductor_number=18 Winding=PhaseC PolarityType=Positive
  PhCRe_5: Coil Objects=Coil_5 Conductor_number=18 Winding=PhaseC PolarityType=Negative
  PhC_5: Coil Objects=CoilRe_13 Conductor_number=18 Winding=PhaseC PolarityType=Positive
  PhB_6: Coil Objects=Coil_6 Conductor_number=18 Winding=PhaseB PolarityType=Positive
  PhBRe_6: Coil Objects=CoilRe_14 Conductor_number=18 Winding=PhaseB PolarityType=Negative
  PhB_7: Coil Objects=Coil_7 Conductor_number=18 Winding=PhaseB PolarityType=Positive
  PhBRe_7: Coil Objects=CoilRe_15 Conductor_number=18 Winding=PhaseB PolarityType=Negative
  PhB_8: Coil Objects=Coil_8 Conductor_number=18 Winding=PhaseB PolarityType=Positive
  PhBRe_8: Coil Objects=CoilRe_16 Conductor_number=18 Winding=PhaseB PolarityType=Negative
  PhARe_9: Coil Objects=Coil_9 Conductor_number=18 Winding=PhaseA PolarityType=Negative
  PhA_9: Coil Objects=CoilRe_17 Conductor_number=18 Winding=PhaseA PolarityType=Positive
  PhARe_10: Coil Objects=Coil_10 Conductor_number=18 Winding=PhaseA PolarityType=Negative
  PhA_10: Coil Objects=CoilRe_18 Conductor_number=18 Winding=PhaseA PolarityType=Positive
  PhARe_11: Coil Objects=Coil_11 Conductor_number=18 Winding=PhaseA PolarityType=Negative
  PhA_11: Coil Objects=CoilRe_19 Conductor_number=18 Winding=PhaseA PolarityType=Positive
  PhC_12: Coil Objects=Coil_12 Conductor_number=18 Winding=PhaseC PolarityType=Positive
  PhCRe_12: Coil Objects=CoilRe_20 Conductor_number=18 Winding=PhaseC PolarityType=Negative
  PhC_13: Coil Objects=Coil_13 Conductor_number=18 Winding=PhaseC PolarityType=Positive
  PhCRe_13: Coil Objects=CoilRe_21 Conductor_number=18 Winding=PhaseC PolarityType=Negative
  PhC_14: Coil Objects=Coil_14 Conductor_number=18 Winding=PhaseC PolarityType=Positive
  PhCRe_14: Coil Objects=CoilRe_22 Conductor_number=18 Winding=PhaseC PolarityType=Negative
  PhBRe_15: Coil Objects=Coil_15 Conductor_number=18 Winding=PhaseB PolarityType=Negative
  PhB_15: Coil Objects=CoilRe_23 Conductor_number=18 Winding=PhaseB PolarityType=Positive
  PhBRe_16: Coil Objects=Coil_16 Conductor_number=18 Winding=PhaseB PolarityType=Negative
  PhB_16: Coil Objects=CoilRe_24 Conductor_number=18 Winding=PhaseB PolarityType=Positive
  PhBRe_17: Coil Objects=Coil_17 Conductor_number=18 Winding=PhaseB PolarityType=Negative
  PhB_17: Coil Objects=CoilRe_25 Conductor_number=18 Winding=PhaseB PolarityType=Positive
  PhA_18: Coil Objects=Coil_18 Conductor_number=18 Winding=PhaseA PolarityType=Positive
  PhARe_18: Coil Objects=CoilRe_26 Conductor_number=18 Winding=PhaseA PolarityType=Negative
  PhA_19: Coil Objects=Coil_19 Conductor_number=18 Winding=PhaseA PolarityType=Positive
  PhARe_19: Coil Objects=CoilRe_27 Conductor_number=18 Winding=PhaseA PolarityType=Negative
  PhA_20: Coil Objects=Coil_20 Conductor_number=18 Winding=PhaseA PolarityType=Positive
  PhARe_20: Coil Objects=CoilRe_28 Conductor_number=18 Winding=PhaseA PolarityType=Negative
  PhCRe_21: Coil Objects=Coil_21 Conductor_number=18 Winding=PhaseC PolarityType=Negative
  PhC_21: Coil Objects=CoilRe_29 Conductor_number=18 Winding=PhaseC PolarityType=Positive
  PhCRe_22: Coil Objects=Coil_22 Conductor_number=18 Winding=PhaseC PolarityType=Negative
  PhC_22: Coil Objects=CoilRe_30 Conductor_number=18 Winding=PhaseC PolarityType=Positive
  PhCRe_23: Coil Objects=Coil_23 Conductor_number=18 Winding=PhaseC PolarityType=Negative
  PhC_23: Coil Objects=CoilRe_31 Conductor_number=18 Winding=PhaseC PolarityType=Positive
  PhB_24: Coil Objects=Coil_24 Conductor_number=18 Winding=PhaseB PolarityType=Positive
  PhBRe_24: Coil Objects=CoilRe_32 Conductor_number=18 Winding=PhaseB PolarityType=Negative
  PhB_25: Coil Objects=Coil_25 Conductor_number=18 Winding=PhaseB PolarityType=Positive
  PhBRe_25: Coil Objects=CoilRe_33 Conductor_number=18 Winding=PhaseB PolarityType=Negative
  PhB_26: Coil Objects=Coil_26 Conductor_number=18 Winding=PhaseB PolarityType=Positive
  PhBRe_26: Coil Objects=CoilRe_34 Conductor_number=18 Winding=PhaseB PolarityType=Negative
  PhARe_27: Coil Objects=Coil_27 Conductor_number=18 Winding=PhaseA PolarityType=Negative
  PhA_27: Coil Objects=CoilRe_35 Conductor_number=18 Winding=PhaseA PolarityType=Positive
  PhARe_28: Coil Objects=Coil_28 Conductor_number=18 Winding=PhaseA PolarityType=Negative
  PhA_28: Coil Objects=CoilRe_0 Conductor_number=18 Winding=PhaseA PolarityType=Positive
  PhARe_29: Coil Objects=Coil_29 Conductor_number=18 Winding=PhaseA PolarityType=Negative
  PhA_29: Coil Objects=CoilRe_1 Conductor_number=18 Winding=PhaseA PolarityType=Positive
  PhC_30: Coil Objects=Coil_30 Conductor_number=18 Winding=PhaseC PolarityType=Positive
  PhCRe_30: Coil Objects=CoilRe_2 Conductor_number=18 Winding=PhaseC PolarityType=Negative
  PhC_31: Coil Objects=Coil_31 Conductor_number=18 Winding=PhaseC PolarityType=Positive
  PhCRe_31: Coil Objects=CoilRe_3 Conductor_number=18 Winding=PhaseC PolarityType=Negative
  PhC_32: Coil Objects=Coil_32 Conductor_number=18 Winding=PhaseC PolarityType=Positive
  PhCRe_32: Coil Objects=CoilRe_4 Conductor_number=18 Winding=PhaseC PolarityType=Negative
  PhBRe_33: Coil Objects=Coil_33 Conductor_number=18 Winding=PhaseB PolarityType=Negative
  PhB_33: Coil Objects=CoilRe_5 Conductor_number=18 Winding=PhaseB PolarityType=Positive
  PhBRe_34: Coil Objects=Coil_34 Conductor_number=18 Winding=PhaseB PolarityType=Negative
  PhB_34: Coil Objects=CoilRe_6 Conductor_number=18 Winding=PhaseB PolarityType=Positive
  PhBRe_35: Coil Objects=Coil_35 Conductor_number=18 Winding=PhaseB PolarityType=Negative
  PhB_35: Coil Objects=CoilRe_7 Conductor_number=18 Winding=PhaseB PolarityType=Positive
  EndConnection1: End Connection Objects=[Bar, Bar_Separate1..Bar_Separate27] ResistanceValue=1.27107e-06ohm InductanceValue=2.0368e-08H
  PhaseA: Winding Group Type=Voltage IsSolid=false Current=0A Resistance=0.88174ohm Inductance=0.00165885H Voltage=310.269*sin(2*pi*50*time) ParallelBranchesNum=1
  PhaseB: Winding Group Type=Voltage IsSolid=false Current=0A Resistance=0.88174ohm Inductance=0.00165885H Voltage=310.269*sin(2*pi*50*time-2*pi/3) ParallelBranchesNum=1
  PhaseC: Winding Group Type=Voltage IsSolid=false Current=0A Resistance=0.88174ohm Inductance=0.00165885H Voltage=310.269*sin(2*pi*50*time-4*pi/3) ParallelBranchesNum=1
  Y connection: PhaseA, PhaseB, PhaseC
mesh:
  SurfApprox_Bar: SurfApproxBased Objects=[Bar, Bar_Separate1..Bar_Separate27] CurvedSurfaceApproxChoice=ManualSettings SurfDev=0.0655mm NormalDev=15deg
  SurfApprox_Main: SurfApproxBased Objects=[Stator, Rotor, Band, OuterRegion, InnerRegion, Shaft] CurvedSurfaceApproxChoice=ManualSettings SurfDev=0.105mm NormalDev=15deg
  initial mesh: MeshMethod=AnsoftTAU
setups:
  Setup1: Transient NonlinearSolverResidual=0.0001 StopTime=0.2s TimeStep=0.0002s FastReachSteadyState AutoDetectSteadyState FrequencyOfAddedVoltageSource=50Hz StopCriterion=0.005 InitialTimeStep=0.002s MinTimeStep=0.001s MaxTimeStep=0.003s TimeStepErrTolerance=0.0001
reports:
  Torque: Moving1.Torque vs Time on Setup1 : Transient
  Currents: Current(PhaseA), Current(PhaseB), Current(PhaseC) vs Time on Setup1 : Transient
  Induced Voltages: InducedVoltage(PhaseA), InducedVoltage(PhaseB), InducedVoltage(PhaseC) vs Time on Setup1 : Transient
  Flux Linkages: FluxLinkage(PhaseA), FluxLinkage(PhaseB), FluxLinkage(PhaseC) vs Time on Setup1 : Transient
  Voltages: InputVoltage(PhaseA), InputVoltage(PhaseB), InputVoltage(PhaseC) vs Time on Setup1 : Transient
  Powers: InputVoltage(PhaseA)*Current(PhaseA) + InputVoltage(PhaseB)*Current(PhaseB) + InputVoltage(PhaseC)*Current(PhaseC), Moving1.Speed*Moving1.Torque vs Time on Setup1 : Transient

design Maxwell2DDesign2 (Maxwell 2D, Transient, XY geometry, model units mm)
options: ModelDepth=135.2mm SkewModelType=0 SkewAngle=12.8571deg NumberOfSlices=5 PlotFieldOnSlice=0
variables:
  fractions = 1
geometry:
  Band [vacuum] = user_primitive(RMxprt/Band, DiaGap=131.5mm, DiaYoke=48mm, Length=0mm, SegAngle=0deg, Fractions=1, HalfAxial=0, InfoCore=0)
  Shaft [M19_24G_2DSF0.950] = user_primitive(RMxprt/Band, DiaGap=131.5mm, DiaYoke=48mm, Length=0mm, SegAngle=0deg, Fractions=1, HalfAxial=0, InfoCore=100)
  OuterRegion [vacuum] = user_primitive(RMxprt/Band, DiaGap=131.5mm, DiaYoke=210mm, Length=0mm, SegAngle=0deg, Fractions=fractions, HalfAxial=0, InfoCore=100)
  Tool = user_primitive(RMxprt/Band, DiaGap=131.5mm, DiaYoke=210mm, Length=0mm, SegAngle=0deg, Fractions=fractions, HalfAxial=0, InfoCore=1)
  Stator [M19_24G_2DSF1.230] = user_primitive(RMxprt/SlotCore, DiaGap=132mm, DiaYoke=210mm, Length=0mm, Skew=0deg, Slots=36, SlotType=2, Hs0=0.5mm, Hs01=0mm, Hs1=1mm, Hs2=19.662134mm, Bs0=3mm, Bs1=7.1062086mm, Bs2=10.546636mm, Rs=0mm, FilletType=0, HalfSlot=0, SegAngle=15deg, LenRegion=0mm, InfoCore=0)
  Coil_0 [copper] = user_primitive(RMxprt/LapCoil, DiaGap=132mm, DiaYoke=210mm, Length=0mm, Skew=0deg, Slots=36, SlotType=2, Hs0=0.5mm, Hs1=1mm, Hs2=19.662134mm, Bs0=3mm, Bs1=7.1062086mm, Bs2=10.546636mm, Rs=0mm, FilletType=0, Layers=2, CoilPitch=8, EndExt=0mm, SpanExt=0mm, BendAngle=0deg, SegAngle=10deg, LenRegion=0mm, InfoCoil=2)
  Coil_1..Coil_35 [copper] = Coil_0.duplicate_around_axis(axis=Z, angle=10deg, total=36)
  CoilRe_0 [copper] = user_primitive(RMxprt/LapCoil, DiaGap=132mm, DiaYoke=210mm, Length=0mm, Skew=0deg, Slots=36, SlotType=2, Hs0=0.5mm, Hs1=1mm, Hs2=19.662134mm, Bs0=3mm, Bs1=7.1062086mm, Bs2=10.546636mm, Rs=0mm, FilletType=0, Layers=2, CoilPitch=8, EndExt=0mm, SpanExt=0mm, BendAngle=0deg, SegAngle=10deg, LenRegion=0mm, InfoCoil=3)
  CoilRe_0.rotate(axis=Z, angle=-80deg)
  CoilRe_1..CoilRe_35 [copper] = CoilRe_0.duplicate_around_axis(axis=Z, angle=10deg, total=36)
  Rotor [M19_24G_2DSF0.950] = user_primitive(RMxprt/SlotCore, DiaGap=131mm, DiaYoke=48mm, Length=0mm, Skew=0deg, Slots=28, SlotType=2, Hs0=0.8mm, Hs01=0mm, Hs1=1mm, Hs2=15mm, Bs0=1mm, Bs1=4mm, Bs2=6mm, Rs=0mm, FilletType=0, HalfSlot=0, SegAngle=15deg, LenRegion=0mm, InfoCore=0)
  Bar [copper_75C] = user_primitive(RMxprt/SquirrelCage, DiaGap=131mm, DiaYoke=48mm, Length=0mm, Skew=0deg, Slots=28, SlotType=2, Hs0=0.8mm, Hs01=0mm, Hs1=1mm, Hs2=15mm, Bs0=1mm, Bs1=4mm, Bs2=6mm, Rs=0mm, FilletType=0, HalfSlot=0, BarEndExt=15mm, RingLength=15mm, RingHeight=20mm, RingDiaGap=0mm, CastRotor=1, SegAngle=15deg, LenRegion=0mm, InfoCoil=0)
  Tool_1 = Tool.copy()
  Bar.subtract(Tool_1)
  Bar_Separate1..Bar_Separate27 [copper_75C] = Bar.separate_bodies()
  InnerRegion [vacuum] = user_primitive(RMxprt/SlotCore, DiaGap=131mm, DiaYoke=48mm, Length=0mm, Skew=0deg, Slots=28, SlotType=2, Hs0=0.8mm, Hs01=0mm, Hs1=1mm, Hs2=15mm, Bs0=1mm, Bs1=4mm, Bs2=6mm, Rs=0mm, FilletType=0, HalfSlot=0, SegAngle=15deg, LenRegion=0mm, InfoCore=100)
  Tool_2 = Tool.copy()
  Band.subtract(Tool_2)
  Tool_3 = Tool.copy()
  InnerRegion.subtract(Tool_3)
  Tool_4 = Tool.copy()
  Shaft.subtract(Tool_4)
  Tool_5 = Tool.copy()
  Stator.subtract(Tool_5)
  Tool_6 = Tool.copy()
  Coil_0.subtract(Tool_6)
  Tool_7 = Tool.copy()
  Coil_1.subtract(Tool_7)
  Tool_8 = Tool.copy()
  Coil_2.subtract(Tool_8)
  Tool_9 = Tool.copy()
  Coil_3.subtract(Tool_9)
  Tool_10 = Tool.copy()
  Coil_4.subtract(Tool_10)
  Tool_11 = Tool.copy()
  Coil_5.subtract(Tool_11)
  Tool_12 = Tool.copy()
  Coil_6.subtract(Tool_12)
  Tool_13 = Tool.copy()
  Coil_7.subtract(Tool_13)
  Tool_14 = Tool.copy()
  Coil_8.subtract(Tool_14)
  Tool_15 = Tool.copy()
  Coil_9.subtract(Tool_15)
  Tool_16 = Tool.copy()
  Coil_10.subtract(Tool_16)
  Tool_17 = Tool.copy()
  Coil_11.subtract(Tool_17)
  Tool_18 = Tool.copy()
  Coil_12.subtract(Tool_18)
  Tool_19 = Tool.copy()
  Coil_13.subtract(Tool_19)
  Tool_20 = Tool.copy()
  Coil_14.subtract(Tool_20)
  Tool_21 = Tool.copy()
  Coil_15.subtract(Tool_21)
  Tool_22 = Tool.copy()
  Coil_16.subtract(Tool_22)
  Tool_23 = Tool.copy()
  Coil_17.subtract(Tool_23)
  Tool_24 = Tool.copy()
  Coil_18.subtract(Tool_24)
  Tool_25 = Tool.copy()
  Coil_19.subtract(Tool_25)
  Tool_26 = Tool.copy()
  Coil_20.subtract(Tool_26)
  Tool_27 = Tool.copy()
  Coil_21.subtract(Tool_27)
  Tool_28 = Tool.copy()
  Coil_22.subtract(Tool_28)
  Tool_29 = Tool.copy()
  Coil_23.subtract(Tool_29)
  Tool_30 = Tool.copy()
  Coil_24.subtract(Tool_30)
  Tool_31 = Tool.copy()
  Coil_25.subtract(Tool_31)
  Tool_32 = Tool.copy()
  Coil_26.subtract(Tool_32)
  Tool_33 = Tool.copy()
  Coil_27.subtract(Tool_33)
  Tool_34 = Tool.copy()
  Coil_28.subtract(Tool_34)
  Tool_35 = Tool.copy()
  Coil_29.subtract(Tool_35)
  Tool_36 = Tool.copy()
  Coil_30.subtract(Tool_36)
  Tool_37 = Tool.copy()
  Coil_31.subtract(Tool_37)
  Tool_38 = Tool.copy()
  Coil_32.subtract(Tool_38)
  Tool_39 = Tool.copy()
  Coil_33.subtract(Tool_39)
  Tool_40 = Tool.copy()
  Coil_34.subtract(Tool_40)
  Tool_41 = Tool.copy()
  Coil_35.subtract(Tool_41)
  Tool_42 = Tool.copy()
  CoilRe_0.subtract(Tool_42)
  Tool_43 = Tool.copy()
  CoilRe_1.subtract(Tool_43)
  Tool_44 = Tool.copy()
  CoilRe_2.subtract(Tool_44)
  Tool_45 = Tool.copy()
  CoilRe_3.subtract(Tool_45)
  Tool_46 = Tool.copy()
  CoilRe_4.subtract(Tool_46)
  Tool_47 = Tool.copy()
  CoilRe_5.subtract(Tool_47)
  Tool_48 = Tool.copy()
  CoilRe_6.subtract(Tool_48)
  Tool_49 = Tool.copy()
  CoilRe_7.subtract(Tool_49)
  Tool_50 = Tool.copy()
  CoilRe_8.subtract(Tool_50)
  Tool_51 = Tool.copy()
  CoilRe_9.subtract(Tool_51)
  Tool_52 = Tool.copy()
  CoilRe_10.subtract(Tool_52)
  Tool_53 = Tool.copy()
  CoilRe_11.subtract(Tool_53)
  Tool_54 = Tool.copy()
  CoilRe_12.subtract(Tool_54)
  Tool_55 = Tool.copy()
  CoilRe_13.subtract(Tool_55)
  Tool_56 = Tool.copy()
  CoilRe_14.subtract(Tool_56)
  Tool_57 = Tool.copy()
  CoilRe_15.subtract(Tool_57)
  Tool_58 = Tool.copy()
  CoilRe_16.subtract(Tool_58)
  Tool_59 = Tool.copy()
  CoilRe_17.subtract(Tool_59)
  Tool_60 = Tool.copy()
  CoilRe_18.subtract(Tool_60)
  Tool_61 = Tool.copy()
  CoilRe_19.subtract(Tool_61)
  Tool_62 = Tool.copy()
  CoilRe_20.subtract(Tool_62)
  Tool_63 = Tool.copy()
  CoilRe_21.subtract(Tool_63)
  Tool_64 = Tool.copy()
  CoilRe_22.subtract(Tool_64)
  Tool_65 = Tool.copy()
  CoilRe_23.subtract(Tool_65)
  Tool_66 = Tool.copy()
  CoilRe_24.subtract(Tool_66)
  Tool_67 = Tool.copy()
  CoilRe_25.subtract(Tool_67)
  Tool_68 = Tool.copy()
  CoilRe_26.subtract(Tool_68)
  Tool_69 = Tool.copy()
  CoilRe_27.subtract(Tool_69)
  Tool_70 = Tool.copy()
  CoilRe_28.subtract(Tool_70)
  Tool_71 = Tool.copy()
  CoilRe_29.subtract(Tool_71)
  Tool_72 = Tool.copy()
  CoilRe_30.subtract(Tool_72)
  Tool_73 = Tool.copy()
  CoilRe_31.subtract(Tool_73)
  Tool_74 = Tool.copy()
  CoilRe_32.subtract(Tool_74)
  Tool_75 = Tool.copy()
  CoilRe_33.subtract(Tool_75)
  Tool_76 = Tool.copy()
  CoilRe_34.subtract(Tool_76)
  Tool_77 = Tool.copy()
  CoilRe_35.subtract(Tool_77)
  Rotor.subtract(Tool)
motion:
  MotionSetup1: Band Move_Type=Rotate Coordinate_System=Global Axis=Z Is_Positive=true InitPos=0deg Angular_Velocity=1455rpm Moment_of_Inertia=0.0304899 Damping=0.0124891 Load_Torque=-24NewtonMeter Objects=Band
  Moving1: Moving Objects=[Shaft, Rotor, Bar, Bar_Separate1..Bar_Separate27, InnerRegion]
boundaries and excitations:
  VectorPotential1: Vector Potential Edges=OuterRegion.edge(at (0, 105, 0)) Value=0
  PhA_0: Coil Objects=Coil_0 Conductor_number=18 Winding=PhaseA PolarityType=Positive
  PhARe_0: Coil Objects=CoilRe_8 Conductor_number=18 Winding=PhaseA PolarityType=Negative
  PhA_1: Coil Objects=Coil_1 Conductor_number=18 Winding=PhaseA PolarityType=Positive
  PhARe_1: Coil Objects=CoilRe_9 Conductor_number=18 Winding=PhaseA PolarityType=Negative
  PhA_2: Coil Objects=Coil_2 Conductor_number=18 Winding=PhaseA PolarityType=Positive
  PhARe_2: Coil Objects=CoilRe_10 Conductor_number=18 Winding=PhaseA PolarityType=Negative
  PhCRe_3: Coil Objects=Coil_3 Conductor_number=18 Winding=PhaseC PolarityType=Negative
  PhC_3: Coil Objects=CoilRe_11 Conductor_number=18 Winding=PhaseC PolarityType=Positive
  PhCRe_4: Coil Objects=Coil_4 Conductor_number=18 Winding=PhaseC PolarityType=Negative
  PhC_4: Coil Objects=CoilRe_12 Conductor_number=18 Winding=PhaseC PolarityType=Positive
  PhCRe_5: Coil Objects=Coil_5 Conductor_number=18 Winding=PhaseC PolarityType=Negative
  PhC_5: Coil Objects=CoilRe_13 Conductor_number=18 Winding=PhaseC PolarityType=Positive
  PhB_6: Coil Objects=Coil_6 Conductor_number=18 Winding=PhaseB PolarityType=Positive
  PhBRe_6: Coil Objects=CoilRe_14 Conductor_number=18 Winding=PhaseB PolarityType=Negative
  PhB_7: Coil Objects=Coil_7 Conductor_number=18 Winding=PhaseB PolarityType=Positive
  PhBRe_7: Coil Objects=CoilRe_15 Conductor_number=18 Winding=PhaseB PolarityType=Negative
  PhB_8: Coil Objects=Coil_8 Conductor_number=18 Winding=PhaseB PolarityType=Positive
  PhBRe_8: Coil Objects=CoilRe_16 Conductor_number=18 Winding=PhaseB PolarityType=Negative
  PhARe_9: Coil Objects=Coil_9 Conductor_number=18 Winding=PhaseA PolarityType=Negative
  PhA_9: Coil Objects=CoilRe_17 Conductor_number=18 Winding=PhaseA PolarityType=Positive
  PhARe_10: Coil Objects=Coil_10 Conductor_number=18 Winding=PhaseA PolarityType=Negative
  PhA_10: Coil Objects=CoilRe_18 Conductor_number=18 Winding=PhaseA PolarityType=Positive
  PhARe_11: Coil Objects=Coil_11 Conductor_number=18 Winding=PhaseA PolarityType=Negative
  PhA_11: Coil Objects=CoilRe_19 Conductor_number=18 Winding=PhaseA PolarityType=Positive
  PhC_12: Coil Objects=Coil_12 Conductor_number=18 Winding=PhaseC PolarityType=Positive
  PhCRe_12: Coil Objects=CoilRe_20 Conductor_number=18 Winding=PhaseC PolarityType=Negative
  PhC_13: Coil Objects=Coil_13 Conductor_number=18 Winding=PhaseC PolarityType=Positive
  PhCRe_13: Coil Objects=CoilRe_21 Conductor_number=18 Winding=PhaseC PolarityType=Negative
  PhC_14: Coil Objects=Coil_14 Conductor_number=18 Winding=PhaseC PolarityType=Positive
  PhCRe_14: Coil Objects=CoilRe_22 Conductor_number=18 Winding=PhaseC PolarityType=Negative
  PhBRe_15: Coil Objects=Coil_15 Conductor_number=18 Winding=PhaseB PolarityType=Negative
  PhB_15: Coil Objects=CoilRe_23 Conductor_number=18 Winding=PhaseB PolarityType=Positive
  PhBRe_16: Coil Objects=Coil_16 Conductor_number=18 Winding=PhaseB PolarityType=Negative
  PhB_16: Coil Objects=CoilRe_24 Conductor_number=18 Winding=PhaseB PolarityType=Positive
  PhBRe_17: Coil Objects=Coil_17 Conductor_number=18 Winding=PhaseB PolarityType=Negative
  PhB_17: Coil Objects=CoilRe_25 Conductor_number=18 Winding=PhaseB PolarityType=Positive
  PhA_18: Coil Objects=Coil_18 Conductor_number=18 Winding=PhaseA PolarityType=Positive
  PhARe_18: Coil Objects=CoilRe_26 Conductor_number=18 Winding=PhaseA PolarityType=Negative
  PhA_19: Coil Objects=Coil_19 Conductor_number=18 Winding=PhaseA PolarityType=Positive
  PhARe_19: Coil Objects=CoilRe_27 Conductor_number=18 Winding=PhaseA PolarityType=Negative
  PhA_20: Coil Objects=Coil_20 Conductor_number=18 Winding=PhaseA PolarityType=Positive
  PhARe_20: Coil Objects=CoilRe_28 Conductor_number=18 Winding=PhaseA PolarityType=Negative
  PhCRe_21: Coil Objects=Coil_21 Conductor_number=18 Winding=PhaseC PolarityType=Negative
  PhC_21: Coil Objects=CoilRe_29 Conductor_number=18 Winding=PhaseC PolarityType=Positive
  PhCRe_22: Coil Objects=Coil_22 Conductor_number=18 Winding=PhaseC PolarityType=Negative
  PhC_22: Coil Objects=CoilRe_30 Conductor_number=18 Winding=PhaseC PolarityType=Positive
  PhCRe_23: Coil Objects=Coil_23 Conductor_number=18 Winding=PhaseC PolarityType=Negative
  PhC_23: Coil Objects=CoilRe_31 Conductor_number=18 Winding=PhaseC PolarityType=Positive
  PhB_24: Coil Objects=Coil_24 Conductor_number=18 Winding=PhaseB PolarityType=Positive
  PhBRe_24: Coil Objects=CoilRe_32 Conductor_number=18 Winding=PhaseB PolarityType=Negative
  PhB_25: Coil Objects=Coil_25 Conductor_number=18 Winding=PhaseB PolarityType=Positive
  PhBRe_25: Coil Objects=CoilRe_33 Conductor_number=18 Winding=PhaseB PolarityType=Negative
  PhB_26: Coil Objects=Coil_26 Conductor_number=18 Winding=PhaseB PolarityType=Positive
  PhBRe_26: Coil Objects=CoilRe_34 Conductor_number=18 Winding=PhaseB PolarityType=Negative
  PhARe_27: Coil Objects=Coil_27 Conductor_number=18 Winding=PhaseA PolarityType=Negative
  PhA_27: Coil Objects=CoilRe_35 Conductor_number=18 Winding=PhaseA PolarityType=Positive
  PhARe_28: Coil Objects=Coil_28 Conductor_number=18 Winding=PhaseA PolarityType=Negative
  PhA_28: Coil Objects=CoilRe_0 Conductor_number=18 Winding=PhaseA PolarityType=Positive
  PhARe_29: Coil Objects=Coil_29 Conductor_number=18 Winding=PhaseA PolarityType=Negative
  PhA_29: Coil Objects=CoilRe_1 Conductor_number=18 Winding=PhaseA PolarityType=Positive
  PhC_30: Coil Objects=Coil_30 Conductor_number=18 Winding=PhaseC PolarityType=Positive
  PhCRe_30: Coil Objects=CoilRe_2 Conductor_number=18 Winding=PhaseC PolarityType=Negative
  PhC_31: Coil Objects=Coil_31 Conductor_number=18 Winding=PhaseC PolarityType=Positive
  PhCRe_31: Coil Objects=CoilRe_3 Conductor_number=18 Winding=PhaseC PolarityType=Negative
  PhC_32: Coil Objects=Coil_32 Conductor_number=18 Winding=PhaseC PolarityType=Positive
  PhCRe_32: Coil Objects=CoilRe_4 Conductor_number=18 Winding=PhaseC PolarityType=Negative
  PhBRe_33: Coil Objects=Coil_33 Conductor_number=18 Winding=PhaseB PolarityType=Negative
  PhB_33: Coil Objects=CoilRe_5 Conductor_number=18 Winding=PhaseB PolarityType=Positive
  PhBRe_34: Coil Objects=Coil_34 Conductor_number=18 Winding=PhaseB PolarityType=Negative
  PhB_34: Coil Objects=CoilRe_6 Conductor_number=18 Winding=PhaseB PolarityType=Positive
  PhBRe_35: Coil Objects=Coil_35 Conductor_number=18 Winding=PhaseB PolarityType=Negative
  PhB_35: Coil Objects=CoilRe_7 Conductor_number=18 Winding=PhaseB PolarityType=Positive
  EndConnection1: End Connection Objects=[Bar, Bar_Separate1..Bar_Separate27] ResistanceValue=1.27107e-06ohm InductanceValue=2.0368e-08H
  PhaseA: Winding Group Type=Voltage IsSolid=false Current=0A Resistance=0.88174ohm Inductance=0.00165885H Voltage=310.269*sin(2*pi*50*time) ParallelBranchesNum=1
  PhaseB: Winding Group Type=Voltage IsSolid=false Current=0A Resistance=0.88174ohm Inductance=0.00165885H Voltage=310.269*sin(2*pi*50*time-2*pi/3) ParallelBranchesNum=1
  PhaseC: Winding Group Type=Voltage IsSolid=false Current=0A Resistance=0.88174ohm Inductance=0.00165885H Voltage=310.269*sin(2*pi*50*time-4*pi/3) ParallelBranchesNum=1
  Y connection: PhaseA, PhaseB, PhaseC
mesh:
  SurfApprox_Bar: SurfApproxBased Objects=[Bar, Bar_Separate1..Bar_Separate27] CurvedSurfaceApproxChoice=ManualSettings SurfDev=0.0655mm NormalDev=15deg
  SurfApprox_Main: SurfApproxBased Objects=[Stator, Rotor, Band, OuterRegion, InnerRegion, Shaft] CurvedSurfaceApproxChoice=ManualSettings SurfDev=0.105mm NormalDev=15deg
  initial mesh: MeshMethod=AnsoftTAU
setups:
  Setup1: Transient NonlinearSolverResidual=0.0001 StopTime=3s TimeStep=0.0005s FastReachSteadyState AutoDetectSteadyState FrequencyOfAddedVoltageSource=50Hz StopCriterion=0.005 InitialTimeStep=0.002s MinTimeStep=0.001s MaxTimeStep=0.003s TimeStepErrTolerance=0.0001
reports:
  Torque: Moving1.Torque vs Time on Setup1 : Transient
  Currents: Current(PhaseA), Current(PhaseB), Current(PhaseC) vs Time on Setup1 : Transient
  Induced Voltages: InducedVoltage(PhaseA), InducedVoltage(PhaseB), InducedVoltage(PhaseC) vs Time on Setup1 : Transient
  Flux Linkages: FluxLinkage(PhaseA), FluxLinkage(PhaseB), FluxLinkage(PhaseC) vs Time on Setup1 : Transient
  Voltages: InputVoltage(PhaseA), InputVoltage(PhaseB), InputVoltage(PhaseC) vs Time on Setup1 : Transient
  Powers: InputVoltage(PhaseA)*Current(PhaseA) + InputVoltage(PhaseB)*Current(PhaseB) + InputVoltage(PhaseC)*Current(PhaseC), Moving1.Speed*Moving1.Torque vs Time on Setup1 : Transient

design RMxprtDesign1 (RMxprt, Three Phase Induction Motor, model units mm)
options: UDDEnabled UDD("Fractions 1")
machine:
  Machine: FrictionLoss=120W WindLoss=80W ReferenceSpeed=1500rpm NumberOfPoles=4 StrayLossFactor=0.01
  Stator: SkewWidth=0 NumberOfSlots=36 LaminationSectors=0 PressBoardThickness=0mm OuterDiameter=210mm InnerDiameter=132mm Length=175mm StackingFactor=0.95 SteelType=M19_24G SlotType=2
  Rotor: OuterDiameter=131mm InnerDiameter=48mm Length=135.2mm SteelType=M19_24G NumberOfSlots=28 SlotType=2 SkewWidth=1 CastRotor BottomSlotType=UserDefinedSlot StackingFactor=0.95
  Shaft: MagneticShaft
  Stator Slot: Hs0=0.5mm Hs1=1mm Hs2=0mm Bs0=3mm Bs1=0mm Bs2=0mm Rs=0mm AutoDesign ToothWidth=0mm
  Stator Winding: WindingType=Whole-Coiled WindingLayers=2 ParallelBranches=1 ConductorsPerSlot=36 CoilPitch=8 EndAdjustment=0mm BaseInnerRadius=0mm TipInnerDiameter=0mm EndClearance=0mm CoilWrap=0mm SlotLiner=0mm WedgeThickness=0mm LayerInsulation=0mm BottomInsulation=0mm LimitedFillFactor=0.75 WdgNumberofPriodicMultipler=1 NumberOfStrands=0 WireWrap=0mm InterturnInsulation=0mm WireDiameter=1.18mm WireWidth=0mm WireThickness=0mm Gauge=0
  Rotor Slot: Hs0=0.8mm Hs1=1mm Hs2=15mm Bs0=1mm Bs1=4mm Bs2=6mm Rs=0mm Hs01=0mm
  Rotor Winding: BarConductorType=copper EndLength=15mm EndRingWidth=15mm EndRingHeight=20mm EndRingConductorType=copper
setups:
  Setup1: TPIM Motor RatedOutputPower=7500W RatedVoltage=380V RatedSpeed=1455rpm OperatingTemperature=75cel LoadType=ConstSpeed Frequency=50Hz WindingConnection=0
reports:
  Current Plot 1: InputCurrent vs RSpeed on Setup1 : Performance
  Torque Plot 1: OutputTorque vs RSpeed on Setup1 : Performance
  Power Plot 1: OutputPower vs RSpeed on Setup1 : Performance
